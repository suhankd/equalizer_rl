.title Channel + CTLE Eye
.lib "/home/royalewithcheese/.ciel/sky130A/libs.tech/ngspice/sky130.lib.spice" tt
Vvin1 SRCP 0 PWL(
+ 0.000000000000000e+00 1.100000
+ 2.000000000000000e-10 1.300000
+ 4.000000000000000e-10 1.300000
+ 6.000000000000000e-10 1.100000
+ 8.000000000000000e-10 1.100000
+ 1.000000000000000e-09 1.300000
+ 1.200000000000000e-09 1.100000
+ 1.400000000000000e-09 1.300000
+ 1.600000000000000e-09 1.100000
+ 1.800000000000000e-09 1.100000
+ 2.000000000000000e-09 1.300000
+ 2.200000000000000e-09 1.300000
+ 2.400000000000000e-09 1.300000
+ 2.600000000000000e-09 1.300000
+ 2.800000000000000e-09 1.300000
+ 3.000000000000000e-09 1.300000
+ 3.200000000000000e-09 1.300000
+ 3.400000000000000e-09 1.100000
+ 3.600000000000000e-09 1.300000
+ 3.800000000000000e-09 1.100000
+ 4.000000000000000e-09 1.300000
+ 4.200000000000000e-09 1.100000
+ 4.400000000000001e-09 1.100000
+ 4.600000000000000e-09 1.300000
+ 4.800000000000000e-09 1.300000
+ 5.000000000000000e-09 1.300000
+ 5.200000000000000e-09 1.100000
+ 5.400000000000000e-09 1.300000
+ 5.600000000000001e-09 1.300000
+ 5.800000000000000e-09 1.100000
+ 6.000000000000000e-09 1.100000
+ 6.200000000000000e-09 1.100000
+ 6.400000000000000e-09 1.100000
+ 6.600000000000000e-09 1.300000
+ 6.800000000000001e-09 1.300000
+ 7.000000000000001e-09 1.100000
+ 7.200000000000000e-09 1.300000
+ 7.400000000000000e-09 1.300000
+ 7.600000000000000e-09 1.100000
+ 7.800000000000000e-09 1.300000
+ 8.000000000000000e-09 1.100000
+ 8.200000000000001e-09 1.300000
+ 8.400000000000001e-09 1.300000
+ 8.600000000000001e-09 1.100000
+ 8.800000000000001e-09 1.100000
+ 9.000000000000000e-09 1.300000
+ 9.200000000000000e-09 1.100000
+ 9.400000000000000e-09 1.300000
+ 9.600000000000000e-09 1.300000
+ 9.800000000000000e-09 1.300000
+ 1.000000000000000e-08 1.300000
+ 1.020000000000000e-08 1.100000
+ 1.040000000000000e-08 1.100000
+ 1.060000000000000e-08 1.100000
+ 1.080000000000000e-08 1.100000
+ 1.100000000000000e-08 1.100000
+ 1.120000000000000e-08 1.300000
+ 1.140000000000000e-08 1.100000
+ 1.160000000000000e-08 1.300000
+ 1.180000000000000e-08 1.300000
+ 1.200000000000000e-08 1.300000
+ 1.220000000000000e-08 1.300000
+ 1.240000000000000e-08 1.100000
+ 1.260000000000000e-08 1.300000
+ 1.280000000000000e-08 1.100000
+ 1.300000000000000e-08 1.100000
+ 1.320000000000000e-08 1.300000
+ 1.340000000000000e-08 1.100000
+ 1.360000000000000e-08 1.100000
+ 1.380000000000000e-08 1.100000
+ 1.400000000000000e-08 1.300000
+ 1.420000000000000e-08 1.100000
+ 1.440000000000000e-08 1.100000
+ 1.460000000000000e-08 1.100000
+ 1.480000000000000e-08 1.300000
+ 1.500000000000000e-08 1.100000
+ 1.520000000000000e-08 1.100000
+ 1.540000000000000e-08 1.100000
+ 1.560000000000000e-08 1.300000
+ 1.580000000000000e-08 1.300000
+ 1.600000000000000e-08 1.300000
+ 1.620000000000000e-08 1.100000
+ 1.640000000000000e-08 1.100000
+ 1.660000000000000e-08 1.300000
+ 1.680000000000000e-08 1.300000
+ 1.700000000000000e-08 1.300000
+ 1.720000000000000e-08 1.100000
+ 1.740000000000000e-08 1.100000
+ 1.760000000000000e-08 1.300000
+ 1.780000000000000e-08 1.300000
+ 1.800000000000000e-08 1.100000
+ 1.820000000000000e-08 1.300000
+ 1.840000000000000e-08 1.300000
+ 1.860000000000000e-08 1.100000
+ 1.880000000000000e-08 1.300000
+ 1.900000000000000e-08 1.100000
+ 1.920000000000000e-08 1.100000
+ 1.940000000000000e-08 1.300000
+ 1.960000000000000e-08 1.300000
+ 1.980000000000000e-08 1.100000
+ 2.000000000000000e-08 1.300000
+ 2.020000000000000e-08 1.100000
+ 2.040000000000000e-08 1.300000
+ 2.060000000000000e-08 1.100000
+ 2.080000000000000e-08 1.300000
+ 2.100000000000000e-08 1.300000
+ 2.120000000000000e-08 1.300000
+ 2.140000000000000e-08 1.300000
+ 2.160000000000000e-08 1.100000
+ 2.180000000000000e-08 1.300000
+ 2.200000000000000e-08 1.100000
+ 2.220000000000000e-08 1.300000
+ 2.240000000000000e-08 1.300000
+ 2.260000000000000e-08 1.100000
+ 2.280000000000000e-08 1.300000
+ 2.300000000000000e-08 1.300000
+ 2.320000000000000e-08 1.100000
+ 2.340000000000000e-08 1.100000
+ 2.360000000000000e-08 1.100000
+ 2.380000000000000e-08 1.100000
+ 2.400000000000000e-08 1.100000
+ 2.420000000000000e-08 1.300000
+ 2.440000000000000e-08 1.300000
+ 2.460000000000000e-08 1.100000
+ 2.480000000000000e-08 1.300000
+ 2.500000000000000e-08 1.300000
+ 2.520000000000000e-08 1.100000
+ 2.540000000000000e-08 1.300000
+ 2.560000000000000e-08 1.300000
+ 2.580000000000000e-08 1.300000
+ 2.600000000000000e-08 1.300000
+ 2.620000000000000e-08 1.300000
+ 2.640000000000000e-08 1.100000
+ 2.660000000000000e-08 1.300000
+ 2.680000000000000e-08 1.300000
+ 2.700000000000000e-08 1.100000
+ 2.720000000000000e-08 1.300000
+ 2.740000000000000e-08 1.100000
+ 2.760000000000000e-08 1.100000
+ 2.780000000000000e-08 1.100000
+ 2.800000000000000e-08 1.300000
+ 2.820000000000000e-08 1.100000
+ 2.840000000000000e-08 1.100000
+ 2.860000000000000e-08 1.100000
+ 2.880000000000000e-08 1.300000
+ 2.900000000000000e-08 1.300000
+ 2.920000000000000e-08 1.100000
+ 2.940000000000000e-08 1.100000
+ 2.960000000000000e-08 1.300000
+ 2.980000000000000e-08 1.100000
+ 3.000000000000000e-08 1.300000
+ 3.020000000000000e-08 1.100000
+ 3.040000000000000e-08 1.300000
+ 3.060000000000000e-08 1.100000
+ 3.080000000000000e-08 1.100000
+ 3.100000000000000e-08 1.300000
+ 3.120000000000000e-08 1.100000
+ 3.140000000000000e-08 1.300000
+ 3.160000000000000e-08 1.300000
+ 3.180000000000000e-08 1.300000
+ 3.200000000000000e-08 1.300000
+ 3.220000000000000e-08 1.300000
+ 3.240000000000000e-08 1.100000
+ 3.260000000000000e-08 1.100000
+ 3.280000000000000e-08 1.100000
+ 3.300000000000000e-08 1.300000
+ 3.320000000000000e-08 1.100000
+ 3.340000000000000e-08 1.100000
+ 3.360000000000000e-08 1.100000
+ 3.380000000000000e-08 1.100000
+ 3.400000000000000e-08 1.100000
+ 3.420000000000000e-08 1.100000
+ 3.440000000000000e-08 1.300000
+ 3.460000000000000e-08 1.300000
+ 3.480000000000000e-08 1.300000
+ 3.500000000000000e-08 1.100000
+ 3.520000000000000e-08 1.300000
+ 3.540000000000000e-08 1.100000
+ 3.560000000000000e-08 1.300000
+ 3.580000000000000e-08 1.300000
+ 3.600000000000000e-08 1.300000
+ 3.620000000000000e-08 1.100000
+ 3.640000000000000e-08 1.100000
+ 3.660000000000000e-08 1.300000
+ 3.680000000000000e-08 1.100000
+ 3.700000000000000e-08 1.100000
+ 3.720000000000000e-08 1.100000
+ 3.740000000000000e-08 1.100000
+ 3.760000000000000e-08 1.100000
+ 3.780000000000000e-08 1.100000
+ 3.800000000000000e-08 1.300000
+ 3.820000000000000e-08 1.300000
+ 3.840000000000000e-08 1.300000
+ 3.860000000000000e-08 1.100000
+ 3.880000000000000e-08 1.300000
+ 3.900000000000000e-08 1.100000
+ 3.920000000000000e-08 1.100000
+ 3.940000000000000e-08 1.100000
+ 3.960000000000000e-08 1.100000
+ 3.980000000000000e-08 1.300000
+ 4.000000000000000e-08 1.100000
+ 4.020000000000000e-08 1.300000
+ 4.040000000000000e-08 1.100000
+ 4.060000000000000e-08 1.300000
+ 4.080000000000000e-08 1.100000
+ 4.100000000000000e-08 1.100000
+ 4.120000000000000e-08 1.300000
+ 4.140000000000000e-08 1.300000
+ 4.160000000000000e-08 1.100000
+ 4.180000000000000e-08 1.300000
+ 4.200000000000000e-08 1.100000
+ 4.220000000000000e-08 1.300000
+ 4.240000000000000e-08 1.300000
+ 4.260000000000000e-08 1.100000
+ 4.280000000000000e-08 1.300000
+ 4.300000000000000e-08 1.100000
+ 4.320000000000000e-08 1.100000
+ 4.340000000000000e-08 1.100000
+ 4.360000000000000e-08 1.100000
+ 4.380000000000000e-08 1.300000
+ 4.400000000000000e-08 1.100000
+ 4.420000000000000e-08 1.100000
+ 4.440000000000000e-08 1.300000
+ 4.460000000000000e-08 1.100000
+ 4.480000000000000e-08 1.300000
+ 4.500000000000000e-08 1.100000
+ 4.520000000000000e-08 1.300000
+ 4.540000000000000e-08 1.300000
+ 4.560000000000000e-08 1.300000
+ 4.580000000000000e-08 1.100000
+ 4.600000000000000e-08 1.100000
+ 4.620000000000000e-08 1.300000
+ 4.640000000000000e-08 1.100000
+ 4.660000000000000e-08 1.300000
+ 4.680000000000000e-08 1.100000
+ 4.700000000000000e-08 1.300000
+ 4.720000000000000e-08 1.300000
+ 4.740000000000000e-08 1.100000
+ 4.760000000000000e-08 1.100000
+ 4.780000000000000e-08 1.300000
+ 4.800000000000000e-08 1.100000
+ 4.820000000000000e-08 1.300000
+ 4.840000000000000e-08 1.100000
+ 4.860000000000001e-08 1.300000
+ 4.880000000000000e-08 1.300000
+ 4.900000000000000e-08 1.100000
+ 4.920000000000000e-08 1.300000
+ 4.940000000000000e-08 1.100000
+ 4.960000000000000e-08 1.300000
+ 4.980000000000000e-08 1.100000
+ 5.000000000000000e-08 1.100000
+ 5.020000000000000e-08 1.100000
+ 5.040000000000000e-08 1.100000
+ 5.060000000000000e-08 1.100000
+ 5.080000000000000e-08 1.300000
+ 5.100000000000000e-08 1.100000
+ 5.120000000000000e-08 1.300000
+ 5.140000000000000e-08 1.100000
+ 5.160000000000000e-08 1.100000
+ 5.180000000000000e-08 1.300000
+ 5.200000000000000e-08 1.300000
+ 5.220000000000000e-08 1.100000
+ 5.240000000000000e-08 1.100000
+ 5.260000000000000e-08 1.300000
+ 5.280000000000000e-08 1.300000
+ 5.300000000000000e-08 1.300000
+ 5.320000000000000e-08 1.100000
+ 5.340000000000000e-08 1.100000
+ 5.360000000000000e-08 1.300000
+ 5.380000000000000e-08 1.300000
+ 5.400000000000000e-08 1.100000
+ 5.420000000000000e-08 1.100000
+ 5.440000000000000e-08 1.100000
+ 5.460000000000000e-08 1.300000
+ 5.480000000000000e-08 1.100000
+ 5.500000000000000e-08 1.100000
+ 5.520000000000000e-08 1.100000
+ 5.540000000000000e-08 1.300000
+ 5.560000000000000e-08 1.100000
+ 5.580000000000000e-08 1.100000
+ 5.600000000000001e-08 1.100000
+ 5.620000000000000e-08 1.100000
+ 5.640000000000000e-08 1.300000
+ 5.660000000000000e-08 1.100000
+ 5.680000000000000e-08 1.100000
+ 5.700000000000000e-08 1.300000
+ 5.720000000000000e-08 1.100000
+ 5.740000000000000e-08 1.300000
+ 5.760000000000000e-08 1.300000
+ 5.780000000000000e-08 1.100000
+ 5.800000000000000e-08 1.300000
+ 5.820000000000000e-08 1.100000
+ 5.840000000000000e-08 1.300000
+ 5.860000000000000e-08 1.100000
+ 5.880000000000000e-08 1.300000
+ 5.900000000000000e-08 1.300000
+ 5.920000000000000e-08 1.300000
+ 5.940000000000000e-08 1.100000
+ 5.960000000000000e-08 1.100000
+ 5.980000000000001e-08 1.100000)
Vvin2 SRCN 0 PWL(
+ 0.000000000000000e+00 1.300000
+ 2.000000000000000e-10 1.100000
+ 4.000000000000000e-10 1.100000
+ 6.000000000000000e-10 1.300000
+ 8.000000000000000e-10 1.300000
+ 1.000000000000000e-09 1.100000
+ 1.200000000000000e-09 1.300000
+ 1.400000000000000e-09 1.100000
+ 1.600000000000000e-09 1.300000
+ 1.800000000000000e-09 1.300000
+ 2.000000000000000e-09 1.100000
+ 2.200000000000000e-09 1.100000
+ 2.400000000000000e-09 1.100000
+ 2.600000000000000e-09 1.100000
+ 2.800000000000000e-09 1.100000
+ 3.000000000000000e-09 1.100000
+ 3.200000000000000e-09 1.100000
+ 3.400000000000000e-09 1.300000
+ 3.600000000000000e-09 1.100000
+ 3.800000000000000e-09 1.300000
+ 4.000000000000000e-09 1.100000
+ 4.200000000000000e-09 1.300000
+ 4.400000000000001e-09 1.300000
+ 4.600000000000000e-09 1.100000
+ 4.800000000000000e-09 1.100000
+ 5.000000000000000e-09 1.100000
+ 5.200000000000000e-09 1.300000
+ 5.400000000000000e-09 1.100000
+ 5.600000000000001e-09 1.100000
+ 5.800000000000000e-09 1.300000
+ 6.000000000000000e-09 1.300000
+ 6.200000000000000e-09 1.300000
+ 6.400000000000000e-09 1.300000
+ 6.600000000000000e-09 1.100000
+ 6.800000000000001e-09 1.100000
+ 7.000000000000001e-09 1.300000
+ 7.200000000000000e-09 1.100000
+ 7.400000000000000e-09 1.100000
+ 7.600000000000000e-09 1.300000
+ 7.800000000000000e-09 1.100000
+ 8.000000000000000e-09 1.300000
+ 8.200000000000001e-09 1.100000
+ 8.400000000000001e-09 1.100000
+ 8.600000000000001e-09 1.300000
+ 8.800000000000001e-09 1.300000
+ 9.000000000000000e-09 1.100000
+ 9.200000000000000e-09 1.300000
+ 9.400000000000000e-09 1.100000
+ 9.600000000000000e-09 1.100000
+ 9.800000000000000e-09 1.100000
+ 1.000000000000000e-08 1.100000
+ 1.020000000000000e-08 1.300000
+ 1.040000000000000e-08 1.300000
+ 1.060000000000000e-08 1.300000
+ 1.080000000000000e-08 1.300000
+ 1.100000000000000e-08 1.300000
+ 1.120000000000000e-08 1.100000
+ 1.140000000000000e-08 1.300000
+ 1.160000000000000e-08 1.100000
+ 1.180000000000000e-08 1.100000
+ 1.200000000000000e-08 1.100000
+ 1.220000000000000e-08 1.100000
+ 1.240000000000000e-08 1.300000
+ 1.260000000000000e-08 1.100000
+ 1.280000000000000e-08 1.300000
+ 1.300000000000000e-08 1.300000
+ 1.320000000000000e-08 1.100000
+ 1.340000000000000e-08 1.300000
+ 1.360000000000000e-08 1.300000
+ 1.380000000000000e-08 1.300000
+ 1.400000000000000e-08 1.100000
+ 1.420000000000000e-08 1.300000
+ 1.440000000000000e-08 1.300000
+ 1.460000000000000e-08 1.300000
+ 1.480000000000000e-08 1.100000
+ 1.500000000000000e-08 1.300000
+ 1.520000000000000e-08 1.300000
+ 1.540000000000000e-08 1.300000
+ 1.560000000000000e-08 1.100000
+ 1.580000000000000e-08 1.100000
+ 1.600000000000000e-08 1.100000
+ 1.620000000000000e-08 1.300000
+ 1.640000000000000e-08 1.300000
+ 1.660000000000000e-08 1.100000
+ 1.680000000000000e-08 1.100000
+ 1.700000000000000e-08 1.100000
+ 1.720000000000000e-08 1.300000
+ 1.740000000000000e-08 1.300000
+ 1.760000000000000e-08 1.100000
+ 1.780000000000000e-08 1.100000
+ 1.800000000000000e-08 1.300000
+ 1.820000000000000e-08 1.100000
+ 1.840000000000000e-08 1.100000
+ 1.860000000000000e-08 1.300000
+ 1.880000000000000e-08 1.100000
+ 1.900000000000000e-08 1.300000
+ 1.920000000000000e-08 1.300000
+ 1.940000000000000e-08 1.100000
+ 1.960000000000000e-08 1.100000
+ 1.980000000000000e-08 1.300000
+ 2.000000000000000e-08 1.100000
+ 2.020000000000000e-08 1.300000
+ 2.040000000000000e-08 1.100000
+ 2.060000000000000e-08 1.300000
+ 2.080000000000000e-08 1.100000
+ 2.100000000000000e-08 1.100000
+ 2.120000000000000e-08 1.100000
+ 2.140000000000000e-08 1.100000
+ 2.160000000000000e-08 1.300000
+ 2.180000000000000e-08 1.100000
+ 2.200000000000000e-08 1.300000
+ 2.220000000000000e-08 1.100000
+ 2.240000000000000e-08 1.100000
+ 2.260000000000000e-08 1.300000
+ 2.280000000000000e-08 1.100000
+ 2.300000000000000e-08 1.100000
+ 2.320000000000000e-08 1.300000
+ 2.340000000000000e-08 1.300000
+ 2.360000000000000e-08 1.300000
+ 2.380000000000000e-08 1.300000
+ 2.400000000000000e-08 1.300000
+ 2.420000000000000e-08 1.100000
+ 2.440000000000000e-08 1.100000
+ 2.460000000000000e-08 1.300000
+ 2.480000000000000e-08 1.100000
+ 2.500000000000000e-08 1.100000
+ 2.520000000000000e-08 1.300000
+ 2.540000000000000e-08 1.100000
+ 2.560000000000000e-08 1.100000
+ 2.580000000000000e-08 1.100000
+ 2.600000000000000e-08 1.100000
+ 2.620000000000000e-08 1.100000
+ 2.640000000000000e-08 1.300000
+ 2.660000000000000e-08 1.100000
+ 2.680000000000000e-08 1.100000
+ 2.700000000000000e-08 1.300000
+ 2.720000000000000e-08 1.100000
+ 2.740000000000000e-08 1.300000
+ 2.760000000000000e-08 1.300000
+ 2.780000000000000e-08 1.300000
+ 2.800000000000000e-08 1.100000
+ 2.820000000000000e-08 1.300000
+ 2.840000000000000e-08 1.300000
+ 2.860000000000000e-08 1.300000
+ 2.880000000000000e-08 1.100000
+ 2.900000000000000e-08 1.100000
+ 2.920000000000000e-08 1.300000
+ 2.940000000000000e-08 1.300000
+ 2.960000000000000e-08 1.100000
+ 2.980000000000000e-08 1.300000
+ 3.000000000000000e-08 1.100000
+ 3.020000000000000e-08 1.300000
+ 3.040000000000000e-08 1.100000
+ 3.060000000000000e-08 1.300000
+ 3.080000000000000e-08 1.300000
+ 3.100000000000000e-08 1.100000
+ 3.120000000000000e-08 1.300000
+ 3.140000000000000e-08 1.100000
+ 3.160000000000000e-08 1.100000
+ 3.180000000000000e-08 1.100000
+ 3.200000000000000e-08 1.100000
+ 3.220000000000000e-08 1.100000
+ 3.240000000000000e-08 1.300000
+ 3.260000000000000e-08 1.300000
+ 3.280000000000000e-08 1.300000
+ 3.300000000000000e-08 1.100000
+ 3.320000000000000e-08 1.300000
+ 3.340000000000000e-08 1.300000
+ 3.360000000000000e-08 1.300000
+ 3.380000000000000e-08 1.300000
+ 3.400000000000000e-08 1.300000
+ 3.420000000000000e-08 1.300000
+ 3.440000000000000e-08 1.100000
+ 3.460000000000000e-08 1.100000
+ 3.480000000000000e-08 1.100000
+ 3.500000000000000e-08 1.300000
+ 3.520000000000000e-08 1.100000
+ 3.540000000000000e-08 1.300000
+ 3.560000000000000e-08 1.100000
+ 3.580000000000000e-08 1.100000
+ 3.600000000000000e-08 1.100000
+ 3.620000000000000e-08 1.300000
+ 3.640000000000000e-08 1.300000
+ 3.660000000000000e-08 1.100000
+ 3.680000000000000e-08 1.300000
+ 3.700000000000000e-08 1.300000
+ 3.720000000000000e-08 1.300000
+ 3.740000000000000e-08 1.300000
+ 3.760000000000000e-08 1.300000
+ 3.780000000000000e-08 1.300000
+ 3.800000000000000e-08 1.100000
+ 3.820000000000000e-08 1.100000
+ 3.840000000000000e-08 1.100000
+ 3.860000000000000e-08 1.300000
+ 3.880000000000000e-08 1.100000
+ 3.900000000000000e-08 1.300000
+ 3.920000000000000e-08 1.300000
+ 3.940000000000000e-08 1.300000
+ 3.960000000000000e-08 1.300000
+ 3.980000000000000e-08 1.100000
+ 4.000000000000000e-08 1.300000
+ 4.020000000000000e-08 1.100000
+ 4.040000000000000e-08 1.300000
+ 4.060000000000000e-08 1.100000
+ 4.080000000000000e-08 1.300000
+ 4.100000000000000e-08 1.300000
+ 4.120000000000000e-08 1.100000
+ 4.140000000000000e-08 1.100000
+ 4.160000000000000e-08 1.300000
+ 4.180000000000000e-08 1.100000
+ 4.200000000000000e-08 1.300000
+ 4.220000000000000e-08 1.100000
+ 4.240000000000000e-08 1.100000
+ 4.260000000000000e-08 1.300000
+ 4.280000000000000e-08 1.100000
+ 4.300000000000000e-08 1.300000
+ 4.320000000000000e-08 1.300000
+ 4.340000000000000e-08 1.300000
+ 4.360000000000000e-08 1.300000
+ 4.380000000000000e-08 1.100000
+ 4.400000000000000e-08 1.300000
+ 4.420000000000000e-08 1.300000
+ 4.440000000000000e-08 1.100000
+ 4.460000000000000e-08 1.300000
+ 4.480000000000000e-08 1.100000
+ 4.500000000000000e-08 1.300000
+ 4.520000000000000e-08 1.100000
+ 4.540000000000000e-08 1.100000
+ 4.560000000000000e-08 1.100000
+ 4.580000000000000e-08 1.300000
+ 4.600000000000000e-08 1.300000
+ 4.620000000000000e-08 1.100000
+ 4.640000000000000e-08 1.300000
+ 4.660000000000000e-08 1.100000
+ 4.680000000000000e-08 1.300000
+ 4.700000000000000e-08 1.100000
+ 4.720000000000000e-08 1.100000
+ 4.740000000000000e-08 1.300000
+ 4.760000000000000e-08 1.300000
+ 4.780000000000000e-08 1.100000
+ 4.800000000000000e-08 1.300000
+ 4.820000000000000e-08 1.100000
+ 4.840000000000000e-08 1.300000
+ 4.860000000000001e-08 1.100000
+ 4.880000000000000e-08 1.100000
+ 4.900000000000000e-08 1.300000
+ 4.920000000000000e-08 1.100000
+ 4.940000000000000e-08 1.300000
+ 4.960000000000000e-08 1.100000
+ 4.980000000000000e-08 1.300000
+ 5.000000000000000e-08 1.300000
+ 5.020000000000000e-08 1.300000
+ 5.040000000000000e-08 1.300000
+ 5.060000000000000e-08 1.300000
+ 5.080000000000000e-08 1.100000
+ 5.100000000000000e-08 1.300000
+ 5.120000000000000e-08 1.100000
+ 5.140000000000000e-08 1.300000
+ 5.160000000000000e-08 1.300000
+ 5.180000000000000e-08 1.100000
+ 5.200000000000000e-08 1.100000
+ 5.220000000000000e-08 1.300000
+ 5.240000000000000e-08 1.300000
+ 5.260000000000000e-08 1.100000
+ 5.280000000000000e-08 1.100000
+ 5.300000000000000e-08 1.100000
+ 5.320000000000000e-08 1.300000
+ 5.340000000000000e-08 1.300000
+ 5.360000000000000e-08 1.100000
+ 5.380000000000000e-08 1.100000
+ 5.400000000000000e-08 1.300000
+ 5.420000000000000e-08 1.300000
+ 5.440000000000000e-08 1.300000
+ 5.460000000000000e-08 1.100000
+ 5.480000000000000e-08 1.300000
+ 5.500000000000000e-08 1.300000
+ 5.520000000000000e-08 1.300000
+ 5.540000000000000e-08 1.100000
+ 5.560000000000000e-08 1.300000
+ 5.580000000000000e-08 1.300000
+ 5.600000000000001e-08 1.300000
+ 5.620000000000000e-08 1.300000
+ 5.640000000000000e-08 1.100000
+ 5.660000000000000e-08 1.300000
+ 5.680000000000000e-08 1.300000
+ 5.700000000000000e-08 1.100000
+ 5.720000000000000e-08 1.300000
+ 5.740000000000000e-08 1.100000
+ 5.760000000000000e-08 1.100000
+ 5.780000000000000e-08 1.300000
+ 5.800000000000000e-08 1.100000
+ 5.820000000000000e-08 1.300000
+ 5.840000000000000e-08 1.100000
+ 5.860000000000000e-08 1.300000
+ 5.880000000000000e-08 1.100000
+ 5.900000000000000e-08 1.100000
+ 5.920000000000000e-08 1.100000
+ 5.940000000000000e-08 1.300000
+ 5.960000000000000e-08 1.300000
+ 5.980000000000001e-08 1.300000)
.subckt channel_section t_in t_out
R1 t_in n2 5.55
L1 t_in n2 470p
R2 n2 n26 2k
R3 n2 n27 1k
C1 n26 0 0.2p
C2 n27 0 0.08p
L2 n2 t_out 1n
C3 t_out 0 0.039p
.ends channel_section

.subckt channel INPUT OUTPUT
XS1 INPUT ch1 channel_section
XS2 ch1 ch2 channel_section
XS3 ch2 ch3 channel_section
XS4 ch3 ch4 channel_section
XS5 ch4 ch5 channel_section
XS6 ch5 ch6 channel_section
XS7 ch6 ch7 channel_section
XS8 ch7 OUTPUT channel_section
.ends channel

.subckt ctle vinp vinn voutp voutn vdd
X1 voutp vinp src_p 0 sky130_fd_pr__nfet_01v8 L=0.15 W=99.6 nf=1
X2 voutn vinn src_n 0 sky130_fd_pr__nfet_01v8 L=0.15 W=99.6 nf=1
RS src_p src_n 90.0
CS src_p src_n 7e-12
RRdp vdd voutp 105.0
RRdn vdd voutn 105.0
Ibiasp src_p 0 0.00125
Ibiasn src_n 0 0.00125
.ends ctle
Vdd vdd 0 1.8V
RPchannel_Rin SRCP Pchannel_INPUT 100
RNchannel_Rin SRCN Nchannel_INPUT 100
RPchannel_Rout Pchannel_OUTPUT 0 100
RNchannel_Rout Nchannel_OUTPUT 0 100
XPCHANNEL Pchannel_INPUT Pchannel_OUTPUT channel
XNCHANNEL Nchannel_INPUT Nchannel_OUTPUT channel
XCTLE Pchannel_OUTPUT Nchannel_OUTPUT voutp voutn vdd ctle
RRloadp voutp 0 1000.0
RRloadn voutn 0 1000.0

.control
.temp 27
set filetype=ascii
tran 2.000000000000000e-12 6.000000000000001e-08
set wr_singlescale
set wr_vecnames
wrdata _eye_e6c9143d.txt v(voutp) v(voutn)
.endc
